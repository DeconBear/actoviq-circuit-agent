* Buck converter skeleton (control abstraction)
* Target: ripple and efficiency studies

.param VIN=12
.param DUTY=0.42
.param FSW=200k
.param L=22u
.param COUT=100u
.param RLOAD=10ohm

V1 vin 0 DC {VIN}
Vsw gate 0 PULSE(0 5 0 10n 10n {DUTY/FSW} {1/FSW})
S1 vin sw gate 0 SWMOD
D1 0 sw DIO
L1 sw vout {L}
C1 vout 0 {COUT}
R1 vout 0 {RLOAD}

.model SWMOD SW(Ron=0.01 Roff=1e6 Vt=2 Vh=0.1)
.model DIO D(Is=1e-14 Rs=0.02 N=1)

.tran 0.1u 2m
.meas tran vout_avg AVG v(vout) FROM=1m TO=2m
.meas tran vout_max MAX v(vout) FROM=1m TO=2m
.meas tran vout_min MIN v(vout) FROM=1m TO=2m
.end
